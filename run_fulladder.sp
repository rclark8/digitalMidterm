.include fulladder_updated.sp
.global vdd vss

Vdd vdd vss dc 3.3v
Vss vss 0 0

Xdut
